| Texas Instruments Incorporated
| Triple 2-Channel Analog Multiplexers/Demultiplexers
| Marketing part#   Voltage Range   Package-type   #pins/pkg drawing
| SN74LV4053AD   2.0V - 5.5V   SOIC   16-pin D
| SN74LV4053AN   2.0V - 5.5V   PDIP   16-pin N
| SN74LV4053ARGY   2.0V - 5.5V   TQFN   16-pin RGY
| SN74LV4053APW   2.0V - 5.5V   TSSOP   16-pin PW
| SN74LV4053ANS   2.0V - 5.5V   SOP   16-pin NS
| SN74LV4053ADGV   2.0V - 5.5V   SOT   16-pin DGV
| SN74LV4053ADB   2.0V - 5.5V   SSOP   16-pin DB
[IBIS Ver]   4.1
[File Name]   sn74lv4053a.ibs
[File Rev]   1.0
[Date]   4/17/2015
[Source]   Data created from lab measurements at TI.
   Texas Instruments Incorporated.
   Webench Design Center
   12500 TI Blvd
   Dallas, TX -75243
   For Support e-mail: elab_ibis@list.ti.com
[Notes]   Revision History
   Rev 1.0: 04/17/2015
   - Series Switch model Ground referenced, PMOS based,
   Vtable = Vmeasured. No VCC offset since gate is at GND
[Disclaimer]  This model is designed as an aid for customers of Texas Instruments
 TI and its licensors and suppliers make no warranties, either expressed
 or implied, with respect to this  model, including the warranties of
 merchantability or fitness for a particular purpose.
 The model is provided solely on an "as is" basis. The entire risk as to
 its quality and performance is with the customer.
[Copyright] (C)Copyright 2015 Texas Instruments Incorporated.
   All rights reserved.
| Component SN74LV4053AD 16-pin SOIC
[Component]   LV4053AD
[Manufacturer]   Texas Instruments, Inc.
[Package]
|   typ   min   max
R_pkg   0.0997   0.0884   0.1093
L_pkg   2.7936n   2.1211n   3.7013n
C_pkg   0.6151p   0.4729p   0.8304p
[Pin]   signal_name   model_name   R_pin   L_pin   C_pin
1   2Y1   IO   0.10760  3.70131n  0.82840p
2   2Y0   IO   0.10934  3.16767n  0.67381p
3   3Y1   IO   0.09893  2.27118n  0.48648p
4   3-COM   IOC   0.08836  2.12108n  0.47394p
5   3Y0   IO   0.08848  2.12500n  0.47286p
6   INH   INH   0.09406  2.19581n  0.48132p
7   GND   GND   0.10425  3.08322n  0.67283p
8   GND   GND   0.10407  3.64244n  0.82794p
9   C   ABC   0.10560  3.66814n  0.83036p
10   B   ABC   0.10643  3.11992n  0.67586p
11   A   ABC   0.09819  2.26511n  0.48571p
12   1Y0   IO   0.08918  2.13680n  0.47501p
13   1Y1   IO   0.08874  2.12708n  0.47429p
14   1-COM   IOC   0.09709  2.24058n  0.48400p
15   2-COM   IOC   0.10934  3.16767n  0.67381p
16   VCC   POWER   0.10540  3.66461n  0.82518p
| Component SN74LV4053AN 16-pin PDIP
[Component]   LV4053AN
[Manufacturer]   Texas Instruments, Inc.
[Package]
|   typ   min   max
R_pkg   0.1287   0.1212   0.1358
L_pkg   7.3748n   4.9087n   10.228n
C_pkg   1.1641p   0.8988p   1.4750p
[Pin]   signal_name   model_name   R_pin   L_pin   C_pin
1   2Y1   IO   0.13372 10.22776n  1.47502p
2   2Y0   IO   0.13311  8.42282n  1.35886p
3   3Y1   IO   0.13580  7.32766n  1.09929p
4   3-COM   IOC   0.12117  4.91249n  0.91223p
5   3Y0   IO   0.12121  4.90867n  0.89876p
6   INH   INH   0.12835  6.23746n  0.97742p
7   GND   GND   0.12618  7.56868n  1.21740p
8   GND   GND   0.12793  9.35359n  1.37106p
9   C   ABC   0.12900  9.36738n  1.37370p
10   B   ABC   0.12754  7.55994n  1.22445p
11   A   ABC   0.13196  6.30434n  0.98133p
12   1Y0   IO   0.12174  4.93532n  0.89923p
13   1Y1   IO   0.12140  4.91332n  0.91194p
14   1-COM   IOC   0.13438  7.30137n  1.09748p
15   2-COM   IOC   0.13335  8.45363n  1.35524p
16   VCC   POWER   0.13204 10.20268n  1.47159p
| Component SN74LV4053ARGY 16-pin VQFN
[Component]   LV4053ARGY
[Manufacturer]   Texas Instruments, Inc.
[Package]
|   typ   min   max
R_pkg   0.0971   0.0901   0.1043
L_pkg   1.3639n   1.2499n   1.4844n
C_pkg   0.2387p   0.2273p   0.2523p
[Pin]   signal_name   model_name   R_pin   L_pin   C_pin
1   2Y1   IO   0.10427  1.48435n  0.22734p
2   2Y0   IO   0.10386  1.47924n  0.24199p
3   3Y1   IO   0.09547  1.34182n  0.24684p
4   3-COM   IOC   0.09012  1.25544n  0.23066p
5   3Y0   IO   0.09020  1.25672n  0.22880p
6   INH   INH   0.09123  1.27277n  0.24126p
7   GND   GND   0.09864  1.39315n  0.24661p
8   GND   GND   0.10075  1.42568n  0.24340p
9   C   ABC   0.10198  1.44282n  0.23523p
10   B   ABC   0.10017  1.41074n  0.23844p
11   A   ABC   0.09496  1.32451n  0.24480p
12   1Y0   IO   0.09068  1.25494n  0.23083p
13   1Y1   IO   0.09037  1.24992n  0.23047p
14   1-COM   IOC   0.09423  1.31258n  0.24483p
15   2-COM   IOC   0.10386  1.47058n  0.25227p
16   VCC   POWER   0.10231  1.44783n  0.23498p
| Component SN74LV4053APW 16-pin TSSOP
[Component]   LV4053APW
[Manufacturer]   Texas Instruments, Inc.
[Package]
|   typ   min   max
R_pkg   0.1207   0.1132   0.1279
L_pkg   2.7740n   2.3996n   3.2540n
C_pkg   0.4612p   0.3994p   0.5278p
[Pin]   signal_name   model_name   R_pin   L_pin   C_pin
1   2Y1   IO   0.12505  3.25402n  0.51520p
2   2Y0   IO   0.12791  2.97047n  0.52771p
3   3Y1   IO   0.12257  2.55899n  0.40527p
4   3-COM   IOC   0.11323  2.39958n  0.40460p
5   3Y0   IO   0.11333  2.40286n  0.40277p
6   INH   INH   0.11777  2.48317n  0.39941p
7   GND   GND   0.12232  2.87981n  0.52084p
8   GND   GND   0.12131  3.20139n  0.51126p
9   C   ABC   0.12272  3.22479n  0.51325p
10   B   ABC   0.12441  2.91491n  0.52339p
11   A   ABC   0.12195  2.55327n  0.40349p
12   1Y0   IO   0.11392  2.41296n  0.40518p
13   1Y1   IO   0.11355  2.40488n  0.40479p
14   1-COM   IOC   0.12104  2.53369n  0.40278p
15   2-COM   IOC   0.12791  2.97047n  0.52777p
16   VCC   POWER   0.12288  3.21802n  0.51221p
| Component SN74LV4053ANS 16-pin SOP
[Component]   LV4053ANS
[Manufacturer]   Texas Instruments, Inc.
[Package]
|   typ   min   max
R_pkg   0.1314   0.1172   0.1424
L_pkg   3.2952n   2.8420n   3.9459n
C_pkg   0.4993p   0.4681p   0.5339p
[Pin]   signal_name   model_name   R_pin   L_pin   C_pin
1   2Y1   IO   0.14183  3.94589n  0.53386p
2   2Y0   IO   0.14244  3.43224n  0.50588p
3   3Y1   IO   0.12994  3.20621n  0.49445p
4   3-COM   IOC   0.11718  2.84202n  0.46980p
5   3Y0   IO   0.11729  2.84555n  0.46810p
6   INH   INH   0.12499  3.12417n  0.48868p
7   GND   GND   0.13691  3.34510n  0.49950p
8   GND   GND   0.13784  3.88361n  0.53069p
9   C   ABC   0.13921  3.90771n  0.53263p
10   B   ABC   0.13896  3.38140n  0.50197p
11   A   ABC   0.12928  3.19947n  0.49284p
12   1Y0   IO   0.11793  2.85685n  0.47050p
13   1Y1   IO   0.11753  2.84802n  0.47004p
14   1-COM   IOC   0.12830  3.17731n  0.49207p
15   2-COM   IOC   0.14244  3.43224n  0.50624p
16   VCC   POWER   0.13968  3.90789n  0.53087p
| Component SN74LV4053ADGV 16-pin SOT
[Component]   LV4053ADGV
[Manufacturer]   Texas Instruments, Inc.
[Package]
|   typ   min   max
R_pkg   0.0987   0.0940   0.1021
L_pkg   2.4430n   2.2985n   2.7956n
C_pkg   0.5859p   0.5641p   0.6118p
[Pin]   signal_name   model_name   R_pin   L_pin   C_pin
1   2Y1   IO   0.10205  2.79564n  0.56892p
2   2Y0   IO   0.09958  2.47374n  0.61166p
3   3Y1   IO   0.10129  2.36460n  0.58857p
4   3-COM   IOC   0.09734  2.29922n  0.58252p
5   3Y0   IO   0.09740  2.30126n  0.58048p
6   INH   INH   0.09697  2.29848n  0.58237p
7   GND   GND   0.09399  2.39129n  0.60579p
8   GND   GND   0.09831  2.74174n  0.56410p
9   C   ABC   0.09974  2.76459n  0.56594p
10   B   ABC   0.09590  2.42188n  0.60797p
11   A   ABC   0.10083  2.36078n  0.58623p
12   1Y0   IO   0.09784  2.30846n  0.58293p
13   1Y1   IO   0.09756  2.30252n  0.58268p
14   1-COM   IOC   0.10018  2.34700n  0.58632p
15   2-COM   IOC   0.09958  2.47374n  0.61182p
16   VCC   POWER   0.09989  2.76107n  0.56613p
| Component SN74LV4053ADB 16-pin SSOP
[Component]   LV4053ADB
[Manufacturer]   Texas Instruments, Inc.
[Package]
|   typ   min   max
R_pkg   0.1314   0.1172   0.1424
L_pkg   3.2952n   2.8420n   3.9459n
C_pkg   0.4993p   0.4681p   0.5339p
[Pin]   signal_name   model_name   R_pin   L_pin   C_pin
1   2Y1   IO   0.14183  3.94589n  0.53386p
2   2Y0   IO   0.14244  3.43224n  0.50588p
3   3Y1   IO   0.12994  3.20621n  0.49445p
4   3-COM   IOC   0.11718  2.84202n  0.46980p
5   3Y0   IO   0.11729  2.84555n  0.46810p
6   INH   INH   0.12499  3.12417n  0.48868p
7   GND   GND   0.13691  3.34510n  0.49950p
8   GND   GND   0.13784  3.88361n  0.53069p
9   C   ABC   0.13921  3.90771n  0.53263p
10   B   ABC   0.13896  3.38140n  0.50197p
11   A   ABC   0.12928  3.19947n  0.49284p
12   1Y0   IO   0.11793  2.85685n  0.47050p
13   1Y1   IO   0.11753  2.84802n  0.47004p
14   1-COM   IOC   0.12830  3.17731n  0.49207p
15   2-COM   IOC   0.14244  3.43224n  0.50624p
16   VCC   POWER   0.13968  3.90789n  0.53087p
[Series Switch Groups]
| Function Group States
On  1 /   | A=0 1-COM->1Y0  1Y1=OFF
On  2 /   | A=1 1-COM->1Y1  1Y0=OFF
On  3 /   | B=0 2-COM->2Y0  2Y1=OFF
On  4 /   | B=1 2-COM->2Y1  2Y0=OFF
On  5 /   | C=0 3-COM->3Y0  3Y1=OFF
On  6 /   | C=1 3-COM->3Y1  3Y0=OFF
[Series Pin Mapping]   pin_2   model_name   function_table_group
4   5   IOS_50_S   1
| 4   5   IOS_33_S   1
| 4   5   IOS_20_S   1
4   3   IOS_50_S   2
| 4   3   IOS_33_S   2
| 4   3   IOS_20_S   2
15   2   IOS_50_S   3
| 15   2   IOS_33_S   3
| 15   2   IOS_20_S   3
15   1   IOS_50_S   4
| 15   1   IOS_33_S   4
| 15   1   IOS_20_S   4
14   12   IOS_50_S   5
| 14   12   IOS_33_S   5
| 14   12   IOS_20_S   5
14   13   IOS_50_S   6
| 14   13   IOS_33_S   6
| 14   13   IOS_20_S   6
|[Model Selector] IOS
|IOS_50_S   SWITCH at VCC=5.0V
|IOS_33_S   SWITCH at VCC=3.3V
|IOS_20_S   SWITCH at VCC=2.0V
[Model Selector] IO
IOS_50   Terminator at VCC=5.0V
IOS_33   Terminator at VCC=3.3V
IOS_20   Terminator at VCC=2.0V
[Model Selector] IOC
IOSC_50   Common Pin Terminator at VCC=5.0V
IOSC_33   Common Pin Terminator at VCC=3.3V
IOSC_20   Common Pin Terminator at VCC=2.0V
[Model Selector] ABC
ABC_50   A/B/C input at VCC=5.0V
ABC_33   A/B/C input at VCC=3.3V
ABC_20   A/B/C input at VCC=2.0V
[Model Selector] INH
INH_50   INH input at VCC=5.0V
INH_33   INH input at VCC=3.3V
INH_20   INH input at VCC=2.0V
[Model]   IOS_50_S
Model_type  Series_switch
| variable   typ   min   max
C_comp   0   NA   NA
[Temperature Range]   27   NA   NA
[Voltage range]   5   NA   NA
[On]
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[Off]
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[Model]   IOS_33_S
Model_type  Series_switch
| variable   typ   min   max
C_comp   0   NA   NA
[Temperature Range]   27   NA   NA
[Voltage range]   3.3   NA   NA
[On]
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[Off]
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[Model]   IOS_20_S
Model_type  Series_switch
| variable   typ   min   max
C_comp   0   NA   NA
[Temperature Range]   27   NA   NA
[Voltage range]   2   NA   NA
[On]
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[Off]
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| Models and submodels in the file (15): IOS_50_S (Series_switch), IOS_50 (Terminator), IOSC_50 (Terminator), IOS_33_S (Series_switch), IOS_33 (Terminator), IOSC_33 (Terminator), IOS_20_S (Series_switch), IOS_20 (Terminator), IOSC_20 (Terminator), ABC_50 (Input), ABC_33 (Input), ABC_20 (Input), INH_50 (Input), INH_33 (Input), INH_20 (Input)
